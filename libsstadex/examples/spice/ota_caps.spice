**.subckt ota_caps

* Differential pair equivalent
Rdif_2 net1 vs 1 m=1
Gdif_2 net1 vs vneg vs 1
Rdif_1 vout vs 1 m=1
Gdif_1 vout vs vpos vs 1

* Bias and supplies
I2 vs vss 1
V1 vdd vss 1.8
V_n vneg vss 0.9
V_p vpos vss 0.9

* Active load equivalent
Raload_1 vdd vout 1 m=1
Raload_2 vdd net1 1 m=1

* Main parasitic capacitances
Cout vout vss 1
Cnet1 net1 vss 1
Cvs vs vss 1

* Gate/drain or feed-forward capacitances
Cgd_p vpos vout 1
Cgd_n vneg net1 1

**.ends
.end
