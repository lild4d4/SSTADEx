.subckt {SUBCKT_NAME} VINP VINN VOUTP VOUTN VTAIL
XM1 VOUTP VINP VTAIL VTAIL sg13_lv_nmos W={W_diff} L={L_diff}
XM2 VOUTN VINN VTAIL VTAIL sg13_lv_nmos W={W_diff} L={L_diff}
.ends {SUBCKT_NAME}
