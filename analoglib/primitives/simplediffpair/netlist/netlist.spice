.subckt {SUBCKT_NAME} VINP VINN VOUTP VOUTN VTAIL
M1 VOUTN VINP VTAIL VTAIL sg13_lv_nmos W={width} L={length}
M2 VOUTP VINN VTAIL VTAIL sg13_lv_nmos W={width} L={length}
.ends {SUBCKT_NAME}
