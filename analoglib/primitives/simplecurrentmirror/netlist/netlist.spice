.subckt {SUBCKT_NAME} VINP VINN VOUTP VOUTN VDD
M1 VINN VINP VDD VDD sg13_lv_pmos W={width} L={length}
M2 VOUTN VINP VDD VDD sg13_lv_pmos W={width} L={length}
.ends {SUBCKT_NAME}
