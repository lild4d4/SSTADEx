.subckt {SUBCKT_NAME} VINP VINN VOUTP VOUTN VDD
M1 VOUTP VINP VDD VDD sg13_lv_pmos W={W_al} L={L_al}
M2 VOUTN VINN VDD VDD sg13_lv_pmos W={W_al} L={L_al}
.ends {SUBCKT_NAME}
