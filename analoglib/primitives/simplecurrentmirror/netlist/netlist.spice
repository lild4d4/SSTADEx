.subckt {SUBCKT_NAME} VINP VINN VOUTP VOUTN VDD
XM1 VOUTN VINN VDD VDD sg13_lv_pmos W={W_al} L={L_al}
XM2 VOUTP VINP VDD VDD sg13_lv_pmos W={W_al} L={L_al}
.ends {SUBCKT_NAME}
