.subckt {SUBCKT_NAME} VINP VINN VOUTP VOUTN VSS
M1 VOUTP VINP VSS VSS sg13_lv_nmos w={W_al} l={L_al}
M2 VOUTN VINN VSS VSS sg13_lv_nmos w={W_al} l={L_al}
.ends {SUBCKT_NAME}
